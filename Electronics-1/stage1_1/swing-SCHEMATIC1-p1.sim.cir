** Profile: "SCHEMATIC1-p1"  [ C:\Users\alimi\Desktop\ELEC PROJECT\file1_1\swing-SCHEMATIC1-p1.sim ]

** Creating circuit file "swing-SCHEMATIC1-p1.sim.cir"
** WARNING: THIS AUTOMATICALLY GENERATED FILE MAY BE OVERWRITTEN BY SUBSEQUENT SIMULATIONS

*Libraries:
* Local Libraries :
* From [PSPICE NETLIST] section of C:\Program Files\Orcad\PSpice\PSpice.ini file:
.lib "nom.lib"

*Analysis directives:
.TRAN  0 1000ns 0
.PROBE V(*) I(*) W(*) D(*) NOISE(*)
.INC ".\swing-SCHEMATIC1.net"

.END
