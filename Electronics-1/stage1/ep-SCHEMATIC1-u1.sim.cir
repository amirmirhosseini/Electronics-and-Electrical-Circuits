** Profile: "SCHEMATIC1-u1"  [ C:\Users\alimi\Desktop\ELEC PROJECT\file1\ep-schematic1-u1.sim ]

** Creating circuit file "ep-schematic1-u1.sim.cir"
** WARNING: THIS AUTOMATICALLY GENERATED FILE MAY BE OVERWRITTEN BY SUBSEQUENT SIMULATIONS

*Libraries:
* Local Libraries :
* From [PSPICE NETLIST] section of C:\Program Files\Orcad\PSpice\PSpice.ini file:
.lib "nom.lib"

*Analysis directives:
.TRAN  0 0.5m 0 1u
.PROBE V(*) I(*) W(*) D(*) NOISE(*)
.INC ".\ep-SCHEMATIC1.net"

.END
