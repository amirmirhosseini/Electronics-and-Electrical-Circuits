** Profile: "SCHEMATIC1-s1"  [ c:\users\alimi\desktop\elec project\file1\ep-schematic1-s1.sim ]

** Creating circuit file "ep-schematic1-s1.sim.cir"
** WARNING: THIS AUTOMATICALLY GENERATED FILE MAY BE OVERWRITTEN BY SUBSEQUENT SIMULATIONS

*Libraries:
* Local Libraries :
* From [PSPICE NETLIST] section of C:\Program Files\Orcad\PSpice\PSpice.ini file:
.lib "nom.lib"

*Analysis directives:
.AC DEC 1000 50 100meg
.PROBE V(*) I(*) W(*) D(*) NOISE(*)
.INC ".\ep-SCHEMATIC1.net"

.END
