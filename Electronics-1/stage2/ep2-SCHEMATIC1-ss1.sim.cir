** Profile: "SCHEMATIC1-ss1"  [ C:\Users\alimi\Desktop\ELEC PROJECT\file2\ep2-schematic1-ss1.sim ]

** Creating circuit file "ep2-schematic1-ss1.sim.cir"
** WARNING: THIS AUTOMATICALLY GENERATED FILE MAY BE OVERWRITTEN BY SUBSEQUENT SIMULATIONS

*Libraries:
* Local Libraries :
* From [PSPICE NETLIST] section of C:\Program Files\Orcad\PSpice\PSpice.ini file:
.lib "nom.lib"

*Analysis directives:
.PROBE V(*) I(*) W(*) D(*) NOISE(*)
.INC ".\ep2-SCHEMATIC1.net"

.END
