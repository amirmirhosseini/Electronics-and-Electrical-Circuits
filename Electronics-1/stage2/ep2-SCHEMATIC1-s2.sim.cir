** Profile: "SCHEMATIC1-s2"  [ c:\users\alimi\desktop\elec project\file2\ep2-schematic1-s2.sim ]

** Creating circuit file "ep2-schematic1-s2.sim.cir"
** WARNING: THIS AUTOMATICALLY GENERATED FILE MAY BE OVERWRITTEN BY SUBSEQUENT SIMULATIONS

*Libraries:
* Local Libraries :
* From [PSPICE NETLIST] section of C:\Program Files\Orcad\PSpice\PSpice.ini file:
.lib "nom.lib"

*Analysis directives:
.TRAN  0 0.5ms 0 1u
.PROBE V(*) I(*) W(*) D(*) NOISE(*)
.INC ".\ep2-SCHEMATIC1.net"

.END
